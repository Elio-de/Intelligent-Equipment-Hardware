* sallen_key.cir - unity-gain Sallen-Key low-pass
V1 in 0 AC 1
R1 in n1 10k
R2 n1 p 10k
C1 n1 out 22n
C2 p 0 10n
E1 out 0 p out 1e6
.ac dec 100 10 100k
.probe
.end
