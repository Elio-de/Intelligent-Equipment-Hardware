* opamp_noninverting.cir - gain = 11, ideal E source
V1 in 0 AC 1
R1 in p 10k
Rf out n 100k
Rg n 0 10k
E1 out 0 p n 1e5
.ac dec 100 10 1Meg
.probe
.end
