* adc_sample_rc.cir - source resistance vs sampling time
V1 in 0 PWL(0 0 0.5m 3.3 1.5m 3.3 1.6m 0 2m 0)
R1 in out 10k
C1 out 0 100n
.tran 0 2m 0 1u
.probe
.end
